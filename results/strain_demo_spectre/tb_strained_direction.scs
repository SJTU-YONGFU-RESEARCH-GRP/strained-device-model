simulator lang=spice
* strained direction
.include "strain_wrap.inc"
Valp alpha 0 dc 0.0
Veps eps_s 0 dc 0.005
Vdd d 0 dc 1.0
Vgs g 0 dc 0.55
Vss s 0 dc 0.0
Vbb b 0 dc 0.0
Xwrap d g s b eps_s alpha strain_aware_device nu=0.47 beta=0.6 gamma=0.0 vth0=0.35 mu0=0.02 nu=0.47 beta=0.6 gamma=0.0 beta_r=0.0 gamma_r=0.0 tau_m=1e-15 tau_load=1e-12 tau_unload=1e-12
.dc Valp 0.0 1.5707963267948966 0.1308996938995747
.print dc v(eps_s) v(alpha) i(Vdd)
.end
