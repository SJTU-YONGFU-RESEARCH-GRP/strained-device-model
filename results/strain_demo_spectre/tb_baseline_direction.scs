simulator lang=spice
* baseline strain direction
.include "strain_demo_mos.subckt"
Valp alpha 0 dc 0.0
Veps eps_s 0 dc 0.005
Vdd d 0 dc 1.0
Vgs g 0 dc 0.55
Vss s 0 dc 0.0
Vbb b 0 dc 0.0
Xdev d g s b strain_demo_mos kp=2e-4 vth=0.35
.dc Valp 0.0 1.5707963267948966 0.1308996938995747
.print dc v(eps_s) v(alpha) i(Vdd)
.end
