* strained transfer eps_s=0.005
            .include strain_wrap.inc
            Veps eps_s 0 dc 0.005
            Valp alpha 0 dc 0.0
            Vdd d 0 dc 1.0
Vgs g 0 dc 0
Vss s 0 dc 0.0
Vbb b 0 dc 0.0
            Xwrap d g s b eps_s alpha strain_aware_device nu=0.47 beta=0.8 gamma=0.0 vth0=0.4 mu0=0.04
            .dc Vgs 0.0 1.2 0.049999999999999996
            .print dc v(eps_s) v(g) i(Vdd)
            .end
