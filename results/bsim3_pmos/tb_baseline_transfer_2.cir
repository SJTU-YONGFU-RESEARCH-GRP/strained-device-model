* baseline transfer eps_s=0.005
        .include bsim3_pmos.subckt
        Vdd d 0 dc -1.0
Vgs g 0 dc 0
Vss s 0 dc 0.0
Vbb b 0 dc 0.0

        Xdev d g s b bsim3_pmos W=10u L=180n
        .dc Vgs -1.2 0.0 0.049999999999999996
        .print dc v(g) i(Vdd)
        .end
